let(((Str Import['Str])
     (Test Import['Test])
     (Virtue Import['Virtue])
    )

procedure(Test_emptyp()
    assert(Str->emptyp(""))
    assert(!Str->emptyp("test"))
)

procedure(Test_split()
    assert(Str->split("Hi,how,,you" ",") == '("Hi" "how" "" "you"))
    assert(Str->split("Hi,how,are,you" ",") == '("Hi" "how" "are" "you"))
    assert(Str->split("Hi how  you" " ") == '("Hi" "how" "" "you"))
    assert(Str->split("Hi how are you" " ") == '("Hi" "how" "are" "you"))
)

procedure(Test_trimWhiteSpace()
    assert(Str->trimWhiteSpace("  Hi everyone") == "Hi everyone")
    assert(Str->trimWhiteSpace("  Hi everyone  ") == "Hi everyone")
    assert(Str->trimWhiteSpace("Hi everyone  ") == "Hi everyone")
    assert(Str->trimWhiteSpace("Hi everyone") == "Hi everyone")
    assert(!("Hi everyone  " == "Hi everyone"))
)

procedure(Test_str2bool()
    assert(Str->str2bool("true"))
    assert(Str->str2bool("True"))
    assert(Str->str2bool("TRUE"))
    assert(!Str->str2bool("false"))
    assert(!Str->str2bool("False"))
    assert(!Str->str2bool("FALSE"))
)

procedure(Test_str2bool_error()
    assert(!errset(Str->str2bool("Nothing")))
)

procedure(Test_convertNumber()
    assert(Str->convertNumber("5.0") == 5.0)
    assert(Str->convertNumber("5") == 5)
    assert(floatp(Str->convertNumber("5.0")))
    assert(integerp(Str->convertNumber("5")))
)

procedure(Test_convert()
    assert(Str->convert("true"))
    assert(!Str->convert("false"))
    assert(Str->convert("5") == 5)
    assert(integerp(Str->convert("5")))
    assert(floatp(Str->convert("5.0")))
    assert(Str->convert("5.0") == 5)
    assert(Str->convert("5") == 5.0)
)

procedure(Test_num2str()
    assert(Str->num2str(5) == "5")
    assert(Str->num2str(5.0) == "5.000000")
    assert(Str->num2str(4.5) == "4.500000")
    assert(Str->num2str(10) == "10")
)

procedure(Test_bool2str()
    assert(Str->bool2str('t) == "TRUE")
    assert(Str->bool2str(nil) == "FALSE")
    assert(Str->bool2str("test") == "TRUE")
    assert(!(Str->bool2str('("test")) == "FALSE"))
)

procedure(Test_startsWith()
    assert(Str->startsWith("HiMan" "Hi"))
    assert(Str->startsWith("HiMan" "Hi") == "Man")
    assert(!Str->startsWith("HiMan" "Man"))
    assert(!Str->startsWith("HiManly" "High"))
    assert(Str->startsWith("HiManly" "H"))
)

procedure(Test_endsWith()
    assert(Str->endsWith("HiMan" "Man"))
    assert(Str->endsWith("HiMan" "Man") == "Hi")
    assert(!Str->endsWith("HiManly" "Man"))
    assert(!Str->endsWith("HiManly" "Hi"))
)

procedure(Test_prefixp()
    assert(Str->prefixp("preFix" "pre"))
    assert(!Str->prefixp("notpreFix" "pre"))
    assert(!Str->prefixp("no" "pre"))
)

procedure(Test_PathConcat()
  assert(Str->PathConcat("/absolute" "path" "to" "a" "directory") ==
         "/absolute/path/to/a/directory")
  assert(Str->PathConcat("" "absolute" "path" "to" "a" "directory") ==
         "/absolute/path/to/a/directory")
  assert(Str->PathConcat("/absolute" "path" "to" "a" "file.txt") ==
         "/absolute/path/to/a/file.txt")
)

Test->RunFile(list(nil
  'Test_emptyp Test_emptyp
  'Test_split Test_split
  'Test_trimWhiteSpace Test_trimWhiteSpace
  'Test_str2bool Test_str2bool
  'Test_str2bool_error Test_str2bool_error
  'Test_convertNumber Test_convertNumber
  'Test_convert Test_convert
  'Test_num2str Test_num2str
  'Test_bool2str Test_bool2str
  'Test_startsWith Test_startsWith
  'Test_endsWith Test_endsWith
  'Test_prefixp Test_prefixp
  'Test_PathConcat Test_PathConcat
  )
  ?filepath Virtue->GetCurrentFilePath()
)

)
