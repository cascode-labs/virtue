let(((Dpl Import['Dpl])
     (Test Import['Test])
     (example_dpl list(nil 'key1 "value1" 'key3 "value2"))
    )

procedure(test_PropertyTable()
  let((table)
  table = Dpl->PropertyTable(example_dpl)
  assert(tablep(table))
  assert(length(table) == 2)
  assert(table['key1] == "value1")
  assert(table['key2] == "value2")
))
test_PropertyTable()
)
