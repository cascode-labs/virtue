procedure(Test_List_ensure()
  assert(List->ensure('(1 2 3)) == '(1 2 3)) ; already a list
  assert(List->ensure("testing false") == '("testing false")) ; a string
  assert(List->ensure(1) == '(1)) ; an integer
  assert(List->ensure('()) == '()) ; empty list
)

procedure(Test_List_setDiff()
  assert(List->setDiff('(1 2 3) '(2 3)) == '(1)) ; integers
  assert(List->setDiff('(1 2 3) '(1 2 3)) == '())
  assert(List->setDiff('("A" "B" "CD" "E") '("A" "CD")) == '("B" "E")) ; strings
  assert(List->setDiff('("A" "B" "CD" "E") '("A" "B" "CD" "E")) == '())
)

procedure(Test_List_uniqueList()
  assert(List->uniqueList('(1 2 3 2 3)) == '(3 2 1)) ; integers
  assert(List->uniqueList('(1 2 3)) == '(3 2 1))
  assert(List->uniqueList('("A" "B" "CD" "E" "A" "CD")) == '("B" "CD" "E" "A")) ; strings
  assert(List->uniqueList('("hi" "hello" "hello")) == '("hi" "hello"))
  assert(List->uniqueList('("hi" "hello")) == '("hi" "hello"))
  assert(List->uniqueList('("hi" "hi" "hello" "hello")) == '("hi" "hello"))
  assert(List->uniqueList('("hi" "hi" "hello" "hello" "" "")) == '("hi" "" "hello")) ; multiple empty strings
)

procedure(Test_List_uniqueListOrdered()
  assert(List->uniqueListOrdered('(1 2 3 2 3)) == '(1 2 3)) ; integers
  assert(List->uniqueListOrdered('(1 2 3)) == '(1 2 3))
  assert(List->uniqueListOrdered('("A" "B" "CD" "E" "A" "CD")) == '("A" "B" "CD" "E")) ; strings
  assert(List->uniqueListOrdered('("hi" "hello" "hello")) == '("hi" "hello"))
  assert(List->uniqueListOrdered('("hi" "hello")) == '("hi" "hello"))
  assert(List->uniqueListOrdered('("hi" "hi" "hello" "hello")) == '("hi" "hello"))
  assert(List->uniqueListOrdered('("hi" "hi" "hello" "hello" "" "")) == '("hi" "hello" "")) ; multiple empty strings
)

Test->run(list(
  Test_List_ensure
  Test_List_setDiff
  Test_List_uniqueList
  Test_List_uniqueListOrdered
))
