let(((List VrtImport['List])
     (Test VrtImport['Test])
     (Virtue VrtImport['Virtue])
    )

procedure(Test_ensure()
  assert(List->ensure('(1 2 3)) == '(1 2 3)) ; already a list
  assert(List->ensure("testing false") == '("testing false")) ; a string
  assert(List->ensure(1) == '(1)) ; an integer
  assert(List->ensure('()) == '()) ; empty list
)

procedure(Test_setDiff()
  assert(List->setDiff('(1 2 3) '(2 3)) == '(1)) ; integers
  assert(List->setDiff('(1 2 3) '(1 2 3)) == '())
  assert(List->setDiff('("A" "B" "CD" "E") '("A" "CD")) == '("B" "E")) ; strings
  assert(List->setDiff('("A" "B" "CD" "E") '("A" "B" "CD" "E")) == '())
)

procedure(Test_uniqueList()
  assert(List->uniqueList('(1 2 3 2 3)) == '(3 2 1)) ; integers
  assert(List->uniqueList('(1 2 3)) == '(3 2 1))
  assert(List->uniqueList('("A" "B" "CD" "E" "A" "CD")) == '("B" "CD" "E" "A")) ; strings
  assert(List->uniqueList('("hi" "hello" "hello")) == '("hi" "hello"))
  assert(List->uniqueList('("hi" "hello")) == '("hi" "hello"))
  assert(List->uniqueList('("hi" "hi" "hello" "hello")) == '("hi" "hello"))
  assert(List->uniqueList('("hi" "hi" "hello" "hello" "" "")) == '("hi" "" "hello")) ; multiple empty strings
)

procedure(Test_uniqueListOrdered()
  assert(List->uniqueListOrdered('(1 2 3 2 3)) == '(1 2 3)) ; integers
  assert(List->uniqueListOrdered('(1 2 3)) == '(1 2 3))
  assert(List->uniqueListOrdered('("A" "B" "CD" "E" "A" "CD")) == '("A" "B" "CD" "E")) ; strings
  assert(List->uniqueListOrdered('("hi" "hello" "hello")) == '("hi" "hello"))
  assert(List->uniqueListOrdered('("hi" "hello")) == '("hi" "hello"))
  assert(List->uniqueListOrdered('("hi" "hi" "hello" "hello")) == '("hi" "hello"))
  assert(List->uniqueListOrdered('("hi" "hi" "hello" "hello" "" "")) == '("hi" "hello" "")) ; multiple empty strings
)

procedure(Test_assocKeys()
  assert(List->assocKeys('((1 "A") '(2 "B") '(3 "C"))) == '(1 2 3))
  assert(List->assocKeys('((1 "A"))) == '(1))
  assert(!List->assocKeys(nil))
)

procedure(Test_lint_List()
  assert(sklint(
    ?file "/prj/ids_dev/work_libs/mayberc/skill/virtue/virtue/data_types/List.ils"
    ?outputFile "/prj/ids_dev/work_libs/mayberc/skill/virtue/test/lint_report_List.txt"
    ?prefixes '(Vrt VrtImport)
  ))
)

procedure(Test_lint_test_List()
  assert(sklint(
    ?file "/prj/ids_dev/work_libs/mayberc/skill/virtue/tests/data_types/test_List.ils"
    ?outputFile "/prj/ids_dev/work_libs/mayberc/skill/virtue/test/lint_report_test_List.txt"
    ?prefixes '(Vrt VrtImport)
  ))
)

Test->RunFile(list(nil
  'Test_ensure Test_ensure
  'Test_setDiff Test_setDiff
  'Test_uniqueList Test_uniqueList
  'Test_uniqueListOrdered Test_uniqueListOrdered
  'Test_assocKeys Test_assocKeys
  'Test_lint_List Test_lint_List
  'Test_lint_test_List Test_lint_test_List
  )
  ?filepath Virtue->GetCurrentFilePath()
)

)
