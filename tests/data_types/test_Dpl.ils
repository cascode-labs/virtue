let(((Dpl VrtImport['Dpl])
     (Test VrtImport['Test])
     (Virtue VrtImport['Virtue])
     (example_dpl list(nil 'key1 "value1" 'key3 "value2"))
    )

procedure(test_PropertyTable()
  let((table)
  table = Dpl->PropertyTable(example_dpl)
  assert(tablep(table))
  assert(length(table) == 2)
  assert(table['key1] == "value1")
  assert(table['key2] == "value2")
))

Test->RunFile(list(nil
  'test_PropertyTable test_PropertyTable
  )
  ?filepath Virtue->GetCurrentFilePath()
)

)
