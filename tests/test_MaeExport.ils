let(((Test Import['Test])
     (Virtue Import['Virtue])
    )

procedure(setup_maestro_lcvh()
  let((lib cell view history_name)
  lib = "ids_dev_work"
  cell = "SW_TRAN_sim"
  view = "maestro"
  history_name = "Assembler.45"
  list(lib cell view history_name)
))

procedure(Test_BuildMaestroHistoryInfoTable()
  let((maestro_lib maestro_cell maestro_view history_name sessionName hsdb history_entry info_table)
  maestro_lib = "ids_dev_work"
  maestro_cell = "SW_TRAN_sim"
  maestro_view = "maestro"
  history_name = "Assembler.45"

  sessionName = maeOpenSetup(maestro_lib maestro_cell maestro_view ?histName history_name ?mode "r")
  unless(sessionName
    error("Could not open Maestro cellview"))
  hsdb = axlGetMainSetupDB(sessionName)
  history_entry = axlGetHistoryEntry(hsdb history_name)
  info_table = MaeExport->BuildMaestroHistoryInfoTable(sessionName history_entry)
  assert(info_table["history"]["name"] == history_name)
  assert(info_table["maestro"]["cell"] == maestro_cell)
  assert(info_table["maestro.tests"]["TRANS"]["design_cell"] == maestro_cell)
  Toml->WriteFile("~/test_maestro_info.toml" info_table)
))

Test->RunFile(list(nil
  'Test_BuildMaestroHistoryInfoTable Test_BuildMaestroHistoryInfoTable
)
  ?filepath Virtue->GetCurrentFilePath()
)

)
