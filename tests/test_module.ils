let((dut_package
     (Module VrtImport['Module])
     (Test VrtImport['Test])
    )

procedure(ModuleCat(package string_arg)
  strcat(Module->some_string string_arg)
)

dut_package = list(nil
  'some_string "A")

putprop(dut_package Module->Method(ModuleCat dut_package) 'ModuleCat)

procedure(test_Method()
  assert(dut_Module->ModuleCat("B") == "AB")
)

test_function = Test->NewFunction('test_Method test_Method)
test_function->Run()
test_function->ReportResult()
)
