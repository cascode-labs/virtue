Test = let(
  ((__running_suite nil) (__suite_success_count 0) (__suite_run_count 0))

procedure(run(functionList "l")
  "Run the list of functions as tests.  Each function is considered passing if
   it doesn't throw an error.  The assert function can be used inside the
   function to implement the tests.

   @brief Run a list of test functions.
   @param functionList A list of test function objects to run
   @return success A boolean representing "
  let((function (run_count 0) run_status (success_count 0) (failures nil)
       failure error_details)
  printf("\nRunning %d Tests\n" length(functionList))
  foreach(function functionList
    run_status = errset(
      function()
    )
    run_count = run_count +1
    when(__running_suite
      __suite_run_count = __suite_run_count + 1
    )
    if(run_status then
      success_count = success_count + 1
      printf("%L: Pass\n" function)
      when(__running_suite
        __suite_success_count = __suite_success_count + 1
      )
    else
      error_details = errset.errset
      failures = append1(failures list(function error_details))
      printf("%L: Failure\n   %s\n" function caar(last(error_details)))
    )
  )
  foreach(failure failures
    printf("\nFailed Test Function: %L\n" car(failure))
  )
  printf("\n")
  printf("%d / %d successful\n" success_count run_count)
  success_count == run_count

))

procedure(run_directory_suite(directory_path "t")
  "Run a directory of tests.  Loads each SKILL or SKILL++ file with a 'Test_'
   prefix and reports the results of each.

   @brief Run a directory of test files with each containing a call to Test->run
   @param functionList A list of test function objects to run
   @return success A boolean representing "
  let((files file success)
  reset_suite()
  __running_suite = 't
	files = getDirFiles(directory_path)
  files = remove("run_tests.ils" files)
  files = remove("." files)
  files = remove(".." files)
  when(files
    foreach(file files
      when(Str->endsWith(file ".il") ||
           Str->endsWith(file ".ils") &&
           (Str->prefixp(file "test_") || Str->prefixp(file "Test_"))
        loadi(strcat(directory_path "/" file))
      )
    )
  )
  success = (__suite_success_count == __suite_run_count)
  reset_suite()
  success
))

procedure(reset_suite()
  __running_suite =nil
  __suite_success_count = 0
  __suite_run_count = 0
)

list(nil
  'run run
  'run_directory_suite run_directory_suite
  'reset_suite reset_suite
))
