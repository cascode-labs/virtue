let((MaeExport
     (module_description "Exports information about a Maestro view")
     (Module VrtImport['Module])
     (Toml VrtImport['Toml])
    )

MaeExport = let(()

procedure(ExportMaestroHistoryInfoTable(sessionName hsdb filePath "t")
  let(()
  Toml->Write(BuildMaestroHistoryInfoTable(sessionName hsdb)
              filePath)
))

procedure(BuildMaestroHistoryInfoTable(sessionName historyEntry "tx")
    let((table)
    table = makeTable(strcat("test_bench_info_" sessionName))
    table["history"] = BuildHistoryInfoTable(historyEntry)
    table["maestro"] = BuildMaestroInfoTable(sessionName)
    table["maestro.tests"] = BuildAllTestInfoTables(sessionName)
    table
))

procedure(BuildHistoryInfoTable(historyEntry "gt")
	let((table)
	table = makeTable("history")
	table["name"] = axlGetHistoryName(historyEntry)
  table
))

procedure(BuildMaestroInfoTable(sessionName "t")
    let((table)
	table = makeTable(strcat("maestro_info_" sessionName))
	table["library"] = axlGetSessionLibName(sessionName)
    table["cell"] = axlGetSessionCellName(sessionName)
    table["view"] = axlGetSessionViewName(sessionName)
    table
))

procedure(TestInfoTable(sessionName testName "tt")
    let((table config test)
    "Reads a test's info into a table"
    table = makeTable(testName)
    test = maeGetTestSession(testName ?session sessionName)
    table["design_library"] = asiGetDesignLibName(test)
    table["design_cell"] = asiGetDesignCellName(test)
    table["design_view"] = asiGetDesignViewName(test)
    if(hdbIsConfig(table["design_library"] table["design_cell"] table["design_view"]) then
        table["schematic_library"] = table["design_library"]
        table["schematic_cell"] = table["design_cell"]
        table["schematic_view"] = table["design_view"]
        config = hdbOpen(table["design_library"] table["design_cell"] table["design_view"] "r")
        table["config_library"] = hdbGetTopLibName(config)
        table["config_cell"] = hdbGetTopCellName(config)
        table["config_view"] = hdbGetTopViewName(config)
    else
        table["schematic_library"] = table["design_library"]
        table["schematic_cell"] = table["design_cell"]
        table["schematic_view"] = table["design_view"]
    )
    table
))

procedure(BuildAllTestInfoTables(sessionName)
    let((table tests)
    tests = maeGetSetup(?typeName "tests"
                        ?enabled t
                        ?session sessionName)
    table = makeTable("tests")
    foreach(test tests
        table[test] = TestInfoTable(sessionName test)
    )
    table
))

list(nil
    'ExportMaestroHistoryInfoTable ExportMaestroHistoryInfoTable
    'BuildMaestroHistoryInfoTable BuildMaestroHistoryInfoTable
))

Module->New('MaeExport
            ?module MaeExport
            ?parent VrtImport['Virtue]
            ?description module_description)
VrtImport['MaeExport] = MaeExport
)
