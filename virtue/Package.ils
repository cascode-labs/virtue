let((Package
     (package_description "Create Virtue SKILL packages")
    )

Package = let(()

  procedure(IsPackage(input "g")
    listp(input) && tablep(car(input)) ||
    tablep(input) && tablep(input['_package])
  )

  procedure(New(package_symbol package
                @key project (description "") "sglt")
    "Add a new SKILL Package to Virtue.
    @param package_symbol A symbol of the package name
    @param package The package decomposed property list (DPL) or table
    @param project The top-level package DPL of the project which defines this package
    @brief Add a new SKILL Package to Virtue."
    let((package_table)
    package_table = makeTable(strcat(symbolToString(package_symbol) " package"))
    if(listp(package) then
      package = cons(package_table cdr(package))
    else if(tablep(package) then
      package['_package] = package_table
    else
      error("A package must be a DPL or a table")
    ))
    package_table['symbol] = package_symbol
    when(symbolp(project)
      project = Import[project])
    package_table['project] = project
    package_table['description] = description
    Import[package_symbol] = package
    package
  ))

  procedure(LoadList(package_filepaths @key (root_path "") continue_on_error)
    "loads a list of filepaths."
    let((filepath load_function)
    if(continue_on_error then
      load_function = loadi
    else
      load_function = load)
    foreach(filepath package_filepaths
      load_function(strcat(root_path "/" filepath))
    )
  ))

  procedure(Method(method package_dpl "ul")
    let((new_method)
      procedure(new_method(@rest rest_args "g")
        apply(method cons(package_dpl rest_args))
      )
    new_method
  ))

  procedure(AddMethod(method_symbol method object_dpl "sul")
    putprop(object_dpl Package->Method(method object_dpl) method_symbol)
  )

  procedure(GetPackageTable(package "g")
    if(listp(package) then
      car(package)
    else if(tablep(package) then
      package['_package]
    else
      error("Package must be a DPL or table")
    ))
  )

  procedure(UninitializePackage(package "g")
    if(symbolp(package) then
      Import[package]->
      remove(package Import)
    )
  )

  list(nil
    'New New
    'IsPackage IsPackage
    'LoadList LoadList
    'Method Method
    'AddMethod AddMethod
  )
)

Package->New('Package Package
             ?project Import['Virtue]
             ?description package_description)

)
