printf("Initializing Virtue skill environment\n")
printf("  conda environment prefix:\n  %s\n" getShellEnvVar("CONDA_PREFIX"))

let((prefix path_skill IDS_libs file skillPkgs prj)
	; Load all the init files from a directory
	procedure(loadInitFromDir(dir) let((files file)
		files = getDirFiles(dir)
		files = remove("virtue-environment.ils" files)
		files = remove("." files)
		files = remove(".." files)
		when(files
			foreach(file files
				cond(
					((substring(file -8 8) == "init.ils")
						loadi(strcat(dir "/" file)))
					((substring(file -7 7) == "init.il")
						loadi(strcat(dir "/" file)))
				)
			)
		)
	))

	; Paths
	prefix = getShellEnvVar("CONDA_PREFIX")
	path_skill = strcat(prefix "/lib/skill")
	printf("Loading SKILL packages from:\n %s\n" path_skill)
	;file_path = simplifyFilename(get_filename(piport))
	;dir_path = buildString(reverse(cdr(reverse(parseString(file_path "/")))) "/")

	; Load SKILL lib
	loadInitFromDir(strcat(path_skill "/virtue"))
	;printf("  Loaded Virtue SKILL library\n")

	; Load init files directly from conda env skill lib
	loadInitFromDir(path_skill)

	; Load projects from directories in conda env skill lib
	skillPkgs = getDirFiles(path_skill)
	skillPkgs = remove("virtue" skillPkgs)
	skillPkgs = remove("IDS-skill" skillPkgs)
	skillPkgs = remove("." skillPkgs)
	skillPkgs = remove(".." skillPkgs)
	when(skillPkgs
		printf("  Loading projects from %s: \n" path_skill)
		foreach(prj skillPkgs
			when(isDir(strcat(strcat(path_skill "/" prj)))
				loadInitFromDir(strcat(path_skill "/" prj))))
	)
)

printf("  Done, initialized Virtue environment from:\n %s" skillPkgs)
