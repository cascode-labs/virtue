printf("Initializing Virtue skill environment\n")
when(getShellEnvVar("CONDA_PREFIX")
	printf("  conda environment prefix:\n  %s\n" getShellEnvVar("CONDA_PREFIX")))

let((prefix skillPkgs prj)

	procedure(GetCurrentFileDirectory()
		let((file_path)
		file_path = simplifyFilename(get_filename(piport))
		strcat("/" buildString(reverse(cdr(reverse(parseString(file_path "/")))) "/"))
	))

	procedure(loadInitFromDir(dir)
		"Load all the SKILL and SKILL++ init files from a directory"
		let((files file)
		files = getDirFiles(dir)
		files = remove("virtue-environment.ils" files)
		files = remove("." files)
		files = remove(".." files)
		when(files
			foreach(file files
				cond(
					((substring(file -8 8) == "init.ils")
						loadi(strcat(dir "/" file)))
					((substring(file -7 7) == "init.il")
						loadi(strcat(dir "/" file)))
				)
			)
		)
	))

	; Paths
	;prefix = getShellEnvVar("CONDA_PREFIX")
	;path_skill = strcat(prefix "/lib/skill")
  prefix = cond(
    ;(getShellEnvVar("CONDA_PREFIX")
    ;  prefix = strcat(getShellEnvVar("CONDA_PREFIX") "/lib/skill"))
    (getShellEnvVar("VIRTUE_DEV")
      strcat(GetCurrentFileDirectory() "/../.."))
    ('t strcat(GetCurrentFileDirectory() "/.."))
  )
	printf("Loading SKILL packages from:\n %s\n" prefix)

	; Load SKILL lib
	loadInitFromDir(strcat(prefix "/virtue"))

	; Load init files directly from conda env skill lib
	loadInitFromDir(prefix)

	; Load projects from directories in conda env skill lib
	skillPkgs = getDirFiles(prefix)
	skillPkgs = remove("virtue" skillPkgs)
	skillPkgs = remove("IDS-skill" skillPkgs)
	skillPkgs = remove("." skillPkgs)
	skillPkgs = remove(".." skillPkgs)
	when(skillPkgs
		printf("  Loading projects from %s: \n" prefix)
		foreach(prj skillPkgs
			when(isDir(strcat(strcat(prefix "/" prj)))
				loadInitFromDir(strcat(prefix "/" prj))))
	)
  printf("  Done, initialized Virtue environment from:\n %s" prefix)
)
