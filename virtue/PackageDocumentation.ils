let((Package
     (package_description "Create Virtue SKILL packages"))
    )

Package = let(()

  procedure(FunctionDocStrings(package "l")
    "Reads the documentation string for all the public functions of a package"
    let((property_symbol)
    for(property
      fdoc()
    )
  ))

  list(nil
    'New New
    'IsPackage IsPackage
  )
)

Package->New('Package Package Virtue
             ?description package_description)
)
