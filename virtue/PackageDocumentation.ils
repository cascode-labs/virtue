let((Module
     (module_description "Create Virtue SKILL packages"))
    )

Module = let(()

  procedure(FunctionDocStrings(package "l")
    "Reads the documentation string for all the public functions of a package"
    let((property_symbol)
    for(property
      fdoc()
    )
  ))

  list(nil
    'New New
    'IsModule IsModule
  )
)

Module->New('Module Module Virtue
             ?description module_description)
)
