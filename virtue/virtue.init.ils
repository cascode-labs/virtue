; Define the iport table as a global in both SKILL and SKILL++
inSkill(Import = makeTable("Virtue Package Import Table"))
importSkillVar(Import)

let((Virtue)

Virtue = let(((package_description "SKILL++ Library and package manager")
             )

  procedure(GetCurrentFilePath()
    simplifyFilename(get_filename(piport))
  )

  procedure(GetCurrentFileDirectory()
    let((file_path)
    file_path = GetCurrentFilePath()
    strcat("/" buildString(reverse(cdr(reverse(parseString(file_path "/")))) "/"))
  ))

  procedure(Initialize()
    let((dir_path preinit_packages Package Project virtue_packages lib)
    printf("\nInitializing Virtue SKILL++ Library\n")

    dir_path = GetCurrentFileDirectory()

    loadi(strcat(dir_path "/Package.ils"))
    Package = Import['Package]
    Virtue = Package->New('Virtue Import['Virtue]
      ?project Import['Virtue]
      ?description package_description)

    preinit_packages = list(
      "Str.ils"
      "Toml.ils"
      "Project.ils"
    )
    Package->LoadList(preinit_packages
      ?root_path dir_path
      ?continue_on_error 't)

    Project = Import['Project]
    Project->New(Virtue dir_path)

    virtue_packages = list(
      "List.ils"
    	"test/Test.ils"
    	"Geo.ils"
      "Dpl.ils"
    	; "Sch.ils"
    	"MaeMaestro.ils"
      "MaeExport.ils"
    	; "skillBridgeMenuItems.il"
    	; "filePathFromLCV.il"
      ; "SchNets.il"
      "HdbConfig.ils"
    )
    Package->LoadList(virtue_packages
      ?root_path dir_path
      ?continue_on_error 't)
    printf("  Initialized Virtue SKILL++ Library\n")
  ))

  list(nil
    'Import Import
    'Initialize Initialize
    'GetCurrentFilePath GetCurrentFilePath
    'GetCurrentFileDirectory GetCurrentFileDirectory
))

Import['Virtue] = Virtue
Virtue->Initialize()
)
