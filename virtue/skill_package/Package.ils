let((Package
     (module_description "Registers a SKILL project with Virtue")
     (Module VrtImport['Module])
    )

Package = let(((PackageModules makeTable("virtue package modules")))

  procedure(New(module_symbol
                @key module (description "") project_init_dir_path "sggtt")
    "Register a new package, adding it to VrtImport.  This also adds a set of
     useful variables about the project to the package's metadata."
    let((config_filepaths config_filepath)

    module = Module->New(module_symbol
                         ?module module
                         ?description description)
    module['__metadata__]['package] = module
    module['__metadata__]['project_root_path] = project_init_dir_path
    module['__metadata__]['is_package] = 't
    register_package(module)
    VrtImport[module_symbol] = module
    module
  ))

  procedure(register_package(module "g")
    PackageModules[module['__metadata__]['symbol]] = module
  )

  procedure(GetPackageMetadata(package_in "g")
    "Returns the package's metadata table."
    package_in['__metadata__]
  )

  list(nil
    'New New
    'PackageModules PackageModules
    'GetPackageMetadata GetPackageMetadata
  )
)

VrtImport['Module]->New('Package
             ?module Package
             ?parent VrtImport['Virtue]
             ?description module_description)
VrtImport['Package] = Package
)
