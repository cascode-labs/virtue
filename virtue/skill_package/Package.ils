let((Package
     (module_description "Registers a SKILL project with Virtue")
    )

Package = let(((PackageModules makeTable("virtue package modules")))

  procedure(New(module project_init_dir_path "gt")
    "Adds a set of useful variables about the project to the
    package's data_table."
    let((package_table config_filepaths config_filepath)

    module['__metadata__]['project_root_path] = project_init_dir_path
    register_package(module)
    module
  ))

  procedure(register_package(module "g")

    PackageModules[module['__metadata__]['symbol]] = module
    Packages[module['__metadata__]['symbol]] = module
  )

  procedure(GetPackageMetadata(package_in "g")
    "Returns the package's metadata table."
    package_in['__metadata__]
  )

  list(nil
    'New New
    'PackageModules PackageModules
    'GetPackageMetadata GetPackageMetadata
  )
)

VrtImport['Module]->New('Package
             ?module Package
             ?package VrtImport['Virtue]
             ?description module_description)

)
