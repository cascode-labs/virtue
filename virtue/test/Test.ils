let((Test
     (Virtue VrtImport['Virtue])
     (Module VrtImport['Module])
     (module_description "SKILL Test framework modeled after PyTest")
    )

Test = let((current_suite)

  procedure(Initialize()
    let((root_path subpackages)
    root_path = Virtue->GetCurrentFileDirectory()
    subpackages = list(
      "TestFunction.ils"
      "TestFile.ils"
      "TestSuite.ils"
      "TestFixtures.ils"
    )
    Module->LoadList(subpackages ?root_path root_path)
  ))

  list(nil
    'Initialize Initialize
    'current_suite current_suite
  )
)

Module->New('Test
            ?module Test
            ?package Virtue
            ?description module_description)
VrtImport['Test] = Test
Test->Initialize()
)
