let(((Test VrtImport['Test])
     (PathConcat VrtImport['Path]->Concat)
     (Fixtures makeTable("Test Fixtures"))
    )
  procedure(TempDirectory(@optional (path_prefix "virtue") "t")
    let((temp_filepath)
    temp_filepath = makeTempFileName(PathConcat(getTempDir() path_prefix))
    createDirHier(temp_filepath)
    temp_filepath
  ))

  Fixtures['TempDirectory] = TempDirectory
  putprop(Test Fixtures 'Fixtures)
)
