let(((Test Import['Test])
     (Package Import['Package])
    )

procedure(NewFile(path @optional test_functions_dpl "tl")
  let((test_file)
  test_file = list(nil
    'path path
    'functions nil
    'functions_tconc nil
    'AddTestFunctions AddTestFunctions
  )
  putprop(test_file Package->Method(AddTestFunctions) 'AddTestFunctions)
  test_file->AddTestFunctions(test_functions_dpl)
))

procedure(Run(test_file "l")
  foreachs(test_function test_file->functions
    test_function->Run()
  )
)

procedure(ReportResults(test_file)
  printf("FILE: %s\n" test_file->path)
  foreachs(test_function test_file->functions
    printf("  ")
    test_function->ReportResults()
  )
)

procedure(AddTestFunctions(test_file test_functions_dpl "ll")
  when(test_functions_dpl
    let((functions_tconc)
    functions_tconc = test_file->functions_tconc
    test_functions_dpl = cdr(test_functions_dpl)
    while(test_functions_dpl
      tconc(functions_tconc
            Test->NewFunction(car(test_functions_dpl) cadr(test_functions_dpl)))
      test_functions_dpl = cddr(test_functions_dpl)
    )
    test_file->functions_tconc = functions_tconc
    test_file->functions = car(functions_tconc)
    )
  )
  't
)

putProp(Test NewFile 'NewFile)
)
