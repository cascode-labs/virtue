let(((Test VrtImport['Test])
     (Module VrtImport['Module])
    )

procedure(NewFile(path @optional test_functions_dpl "tl")
  let((test_file)
  test_file = list(nil
    'path path
    'functions nil
    'functions_tconc nil
    'AddTestFunctions AddTestFunctions
    'ReportResult ReportResult
  )
  putprop(test_file Module->Method(AddTestFunctions test_file) 'AddTestFunctions)
  putprop(test_file Module->Method(ReportResult test_file) 'ReportResult)
  putprop(test_file Module->Method(Run test_file) 'Run)
  putprop(test_file Module->Method(FunctionCount test_file) 'FunctionCount)
  putprop(test_file Module->Method(FunctionPassCount test_file) 'FunctionPassCount)
  test_file->AddTestFunctions(test_functions_dpl)
  test_file
))

procedure(Run(test_file "l")
  printf("Running File: %s \n" test_file->path)
  foreachs(test_function test_file->functions
    test_function->Run()
  )
  printf("  Done Running File: %s \n" test_file->path)
)

procedure(RunFile(test_functions_dpl @key (filepath "") "lt")
  let(((current_suite Test->GetCurrentSuite()))
  test_file = NewFile(filepath test_functions_dpl)
  test_file->Run()
  when(current_suite
    current_suite->AddFile(test_file))
  unless(current_suite
    test_file->ReportResult())
  test_file
))

procedure(ReportResult(test_file "l")
  let((function_count pass_count)
  printf("FILE: %s\n" test_file->path)
  foreachs(test_function test_file->functions
    printf("  ")
    test_function->ReportResult()
  )
  function_count = test_file->FunctionCount()
  pass_count = test_file->FunctionPassCount()
  printf("%n / %n tests passed\n" pass_count function_count)
  if(pass_count == function_count then
    printf("\nALL TESTS PASS!\n\n")
  else
    printf("\n%n TESTS FAILED!\n\n" function_count - pass_count))

))

procedure(AddTestFunctions(test_file test_functions_dpl "ll")
  when(test_functions_dpl
    let((functions_tconc)
    functions_tconc = test_file->functions_tconc
    test_functions_dpl = cdr(test_functions_dpl)
    while(test_functions_dpl
      functions_tconc = tconc(functions_tconc
            Test->NewFunction(car(test_functions_dpl) cadr(test_functions_dpl)))
      test_functions_dpl = cddr(test_functions_dpl)
    )
    test_file->functions_tconc = functions_tconc
    test_file->functions = car(functions_tconc)
    )
  )
  't
)

procedure(FunctionCount(test_file "l")
  length(test_file->functions)
)

procedure(FunctionPassCount(test_file "l")
  let(((pass_count 0) test_function)
  foreachs(test_function test_file->functions
    when(test_function->pass
      pass_count = pass_count + 1)
  )
  pass_count
))

Module->AddFunction(Test 'NewFile NewFile)
Module->AddFunction(Test 'RunFile RunFile)
)
