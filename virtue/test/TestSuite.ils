let(((Test VrtImport['Test])
     (Str VrtImport['Str])
     (Module VrtImport['Module])
     (Path VrtImport['Path])
     current_suite
    )

  procedure(RunDirectory(directory_path @optional (recurse nil) "tg")
    "Run a directory of tests.  Loads each SKILL or SKILL++ file with a 'Test_'
     prefix and reports the results of each.

     @brief Run a directory of test files with each containing a call to Test->RunFile
     @param directory_path Path to a directory of SKILL test scripts
     @return A test suite object"
    let((files file file_path test_files success suite)
    unless(recurse
      ResetSuite()
      current_suite = NewSuite(?path directory_path)
    )
  	files = getDirFiles(directory_path)
    files = remove("run_tests.ils" files)
    files = remove("." files)
    files = remove(".." files)
    when(files
      foreach(file files
        file_path = Path->Concat(directory_path file)
        when(Str->endsWith(file ".il") ||
             Str->endsWith(file ".ils") &&
             (Str->prefixp(file "test_") || Str->prefixp(file "Test_"))
          loadi(file_path)
        )
        when(isDir(file_path)
          RunDirectory(file_path 't)
        )
      )
    )
    unless(recurse
      current_suite->ReportResult()
      suite = current_suite
      Test->ResetSuite()
    )
    suite
  ))

  procedure(NewSuite( @key path "t")
    let((suite)
    suite = list(nil
      'path path
      'files nil
      'pass 't
      'ResetSuite ResetSuite
    )
    Module->AddMethod(suite 'AddFile AddFile)
    Module->AddMethod(suite 'ReportResult ReportResult)
    Module->AddMethod(suite 'FunctionCount FunctionCount)
    Module->AddMethod(suite 'FunctionPassCount FunctionPassCount)
    suite
  ))

  procedure(AddFile(suite file "ll")
    ;suite->files = cons(file suite->files)
    suite->files = append1(suite->files file)
  )

  procedure(ReportResult(suite "l")
    let((function_count pass_count)
    printf("RAN SUITE: %s\n" suite->path)
    foreachs(file suite->files
      printf("  ")
      file->ReportResult()
    )
    function_count = suite->FunctionCount()
    pass_count = suite->FunctionPassCount()
    printf("%n / %n suite tests passed\n" pass_count function_count)
    if(pass_count == function_count then
      printf("\nALL SUITE TESTS PASS!\n\n")
    else
      printf("\n%n SUITE TESTS FAILED!\n\n" function_count - pass_count))
    pass_count == function_count
  ))

  procedure(FunctionCount(suite "l")
    let(((function_count 0))
    foreachs(file suite->files
      function_count = function_count + file->FunctionCount()
    )
    function_count
  ))

  procedure(FunctionPassCount(suite "l")
    let(((pass_count 0))
    foreachs(file suite->files
      pass_count = pass_count + file->FunctionPassCount()
    )
    pass_count
  ))

  procedure(ResetSuite()
    current_suite = nil
  )

  procedure(GetCurrentSuite()
    current_suite)

  putprop(Test RunDirectory 'RunDirectory)
  putprop(Test ResetSuite 'ResetSuite)
  putprop(Test GetCurrentSuite 'GetCurrentSuite)
)
