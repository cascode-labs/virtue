let(((Test Import('Test))
    )

  procedure(ReportResult(result "l")
    let((pass_message)
    if(pass then
      pass_message = "passed"
    else
      pass_message = "failed")
    printf("%s %s\n" result->pass pass_message)
  )

  procedure(NewResult(pass
                      @key (function_name "") error_details "ltttl")
    list(nil
      'pass pass
      'function_name function_name
      'error_details error_details
      'ReportResult ReportResult)
  )
  putProp(Test NewResult 'NewResult)

)
