let((Calculator
     (package_description "A set of VIVA calculator functions")
     (Package Import['Package])
    )

Calculator = let(()
  procedure(Initialize()
    let((package_files)
    package_files = list("abSP.il")
    Package->load_list(package_files)
  ))

  list(nil
    'Initialize Initialize
  )
)

Package->New('Calculator Calculator
             ?project Virtue
             ?description package_description)
)
