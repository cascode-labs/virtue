let((Project
     (package_description "Registers a SKILL project with Virtue")
     (Toml Import['Toml])
     (Package Import['Package])
    )

Project = let(((project_packages makeTable("virtue project packages")))

  procedure(New(project_package project_init_dir_path "lt")
    "Adds a set of useful variables about the project to the project package to the project package's data_table."
    let((package_table config_filepath config_filepath_above)
    package_table = car(project_package)
    config_filepath = Str->pathConcat(project_init_dir_path "pyproject.toml")
    config_filepath_above = Str->pathConcat(project_init_dir_path "../pyproject.toml")
    cond(
      (isFile(config_filepath) nil)
      (isFile(config_filepath_above)
        config_filepath = config_filepath_above)
      (t error(strcat(
          "Could not read the pyproject.toml or skill-project.toml file!\n"
          "Please make sure it is located in the same"
          "directory as the initialization file or the directory directly above it."))
      )
    )
    package_table['project] = read_project_config(config_filepath)
    package_table['project]['project_root_path] = project_init_dir_path
    register_project(project_package)
    project_package
  ))

  procedure(read_project_config(project_init_dir_path "t")
    Toml->ReadFile(project_init_dir_path))

  procedure(register_project(project_package "l")
    project_packages[car(project_package)['symbol]] = project_package)

  /*
  procedure(LoadContext(file_path "t")
    "Load a context and call its initialization function"
    loadContext(file_path)
    callInitProc(Str->PathFileName(file_path))
  )
  */

  list(nil
    'New New
    'ProjectPackages project_packages
  )
)

Package->New('Project Project
             ?project Virtue
             ?description package_description)
)
