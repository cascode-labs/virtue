let(((Test Import('Test))
    )

procedure(NewFile(path @optional test_functions_dpl "tl")
  list(nil
    'path path
    'functions AddTestFunctions(test_functions_dpl))
)

procedure(AddTestFunctions(test_functions_dpl "l")
    # TODO
)

putProp(Test NewFile 'NewFile)
)
