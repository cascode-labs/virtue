let(()
Project = let((project_packages)
procedure(New(project_package "l")
  "Adds a set of useful variables about the project to the project package to the project package's __project__ variable.
   __version__: The Version number of the project
   __project_name__: The project name"
  let((__project__)
  __project__ = list(nil
    'version get_version()
    'name "virtue")
  project_package_car = car(project_package)
  project_package = constar(project_package_car
                            '__project__ __project__
                            cdr(project_package))
  project_package
))

read_project_config()

procedure(Projects()
 project_packages
)

procedure(get_version()

)

procedure(register_project(project_package "l")
  project_packages = append1(project_packages project_package)
)

procedure(Loadi(path "t")

)

)

list(nil
  'LoadModule LoadModule
))

)
