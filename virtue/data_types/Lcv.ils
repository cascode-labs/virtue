let((Lcv
     (module_description
      "Select the lib, cell, view or history name from an ordered list of them.")
    )
Lcv = let(()

procedure(lib(lcv_list "l")
  "Get the library name frim a lcv (lib, cell, view) list"
  car(lcv_list)
)
procedure(cell(lcv_list "l")
  "Get the cell name frim a lcv (lib, cell, view) list"
  cadr(lcv_list)
)

procedure(view(lcv_list "l")
  "Get the view name frim a lcv (lib, cell, view) list"
  caddr(lcv_list)
)

procedure(history(lcvh_list "l")
  "Get the history name frim a lcvh (lib, cell, view, history) list"
  cadddr(lcvh_list)
)

list(nil
  'lib lib
  'cell cell
  'view view
  'history history
))

VrtImport['Module]->New('Lcv
  ?module Lcv
  ?package VrtImport['Virtue]
  ?description module_description)
VrtImport['Lcv] = Lcv
)
