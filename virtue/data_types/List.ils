let((List
     (module_description "List functions")
     (Module VrtImport['Module])
    )

List = let(()

  procedure(ensure(input "g")
    "Ensures the input is a list, making it a list if it isn't one already."
    unless(listp(input)
      input = list(input))
    input
  )

  procedure(setDiff(plusList minusList "ll")
    "Returns plusList with the items in minusList removed"
    let(()
  	foreach(item minusList
  		plusList = remove(item plusList)
  	)
  	plusList
  ))

  procedure(uniqueList(input "l")
    "Returns a list of items of the unique elements from the input list
     It doesn't guarantee the order of the elements but is much faster than the ordered version. "
    let(((table makeTable('uniq_table)))
    foreach(item input
      table[item] = 't
    )
    table->?
  ))

  procedure(uniqueListOrdered(in "l")
    "Returns a list of items of the unique elements from the input list
     while keeping the order between the first unique elements"
    let((out noAdd)
  	out = '()
  	foreach(item in
  		noAdd = member(item out)
  		unless(noAdd
  			out = append(out list(item))
  		)
  	)
  out
  ))

  ;;;;;;;;;;;;;;;;;;;;;;
  ; Obj Instance Lists ;
  ;;;;;;;;;;;;;;;;;;;;;;

  procedure(getSlot(objList slotName "ls")
    "Returns a list of the value of the given slot of each instance in the list

    @param objList A list of skill++ object instances
    @param slotName A symbol of the slot name
    "
  let((out)
  	foreach(obj objList
  		out = tconc(out slotValue(obj slotName))
  	)
  	car(out)
  ))

  ;;;;;;;;;;;;;;;;;;;;;
  ; Association Lists ;
  ;;;;;;;;;;;;;;;;;;;;;

  procedure(assocKeys(assocList "l")
    "Returns all the keys in the specified association list"
    mapcar( 'car assocList)
  )

  list(nil
  	 'ensure ensure
  	 'setDiff setDiff
     'uniqueList uniqueList
     'uniqueListOrdered uniqueListOrdered
  	 'getSlot getSlot
  	 'assocKeys assocKeys
  )
)

Module->New('List
             ?module List
             ?package VrtImport['Virtue]
             ?description module_description)
VrtImport['List] = List
)
