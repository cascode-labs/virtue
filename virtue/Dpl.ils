let((Dpl
     (package_description "Disembodied property list functions")
     (Package Import['Package])
    )
Dpl = let(()

  procedure(Cat(dpl_1 dpl_2 "ll")
    "Appends the data (car) and property lists of dpl_1 and dpl_2."
    cons(append(car(dpl_1) car(dpl_2)) append(cdr(dpl_1) cdr(dpl_2)))
  )

  procedure(PropertyTable(input_dpl "l")
    "Convert a DPL to an association table"
    let((property_list (idx 2) (table makeTable("dpl properties")))
    property_list = cdr(input_dpl)

    while(property_list
      table[car(property_list)] = cadr(property_list)
      property_list = cddr(property_list)
    )
    table
  ))

  list(nil
    'PropertyTable PropertyTable
    'Cat Cat
  )
)

Package->New('Dpl Dpl
             ?project Import['Virtue]
             ?description package_description)
)
