; Define the iport table as a global in both SKILL and SKILL++
inSkill(VrtImport = makeTable("Virtue package import table containing just the latest version of each package"))
importSkillVar(VrtImport)
inSkill(Packages = makeTable("Virtue package import table containing all package versions"))
importSkillVar(Packages)

let((Virtue)

Virtue = let(((module_description "SKILL++ Library and package manager")
             )

  procedure(GetCurrentFilePath()
    "Gets the path to the skill file currently being loaded"
    simplifyFilename(get_filename(piport))
  )

  procedure(GetCurrentFileDirectory()
    "Gets the path to the directory containing the skill file currently being
    loaded"
    let((file_path)
    file_path = GetCurrentFilePath()
    strcat("/" buildString(reverse(cdr(reverse(parseString(file_path "/")))) "/"))
  ))

  procedure(OpenDocumentation()
    system("firefox http://www.cascode-labs.org/virtue/ &")
  )

  procedure(OpenDocumentationLmgrCallback(_menuItem _lib _cell _view _file _cat)
    "Callback to open the Virtue help from the library manager window"
    OpenDocumentation()
  )

  procedure(Initialize()
    let((dir_path preinit_packages Module Project virtue_packages)
    printf("\nInitializing Virtue SKILL++ Library\n")

    dir_path = GetCurrentFileDirectory()

    loadi(strcat(dir_path "/skill_package/Module.ils"))
    Module = VrtImport['Module]
    Virtue = Module->New('Virtue
      ?module VrtImport['Virtue]
      ?package VrtImport['Virtue]
      ?description module_description)

    preinit_packages = list(
      "data_types/Str.ils"
      "data_types/Path.ils"
      "Toml.ils"
      "skill_package/Package.ils"
    )
    Module->LoadList(preinit_packages
      ?root_path dir_path
      ?continue_on_error 't)
    VrtImport['Package]->New(Virtue dir_path)

    virtue_packages = list(
      "data_types/List.ils"
    	"test/Test.ils"
    	"Geo.ils"
      "data_types/Dpl.ils"
      "data_types/Lcv.ils"
      "data_types/Time.ils"
    	; "Sch.ils"
    	"MaeMaestro.ils"
      "MaeExport.ils"
      "HdbConfig.ils"
      "Skillbridge.ils"
    )
    Module->LoadList(virtue_packages
      ?root_path dir_path
      ?continue_on_error 't)
    printf("  Initialized Virtue SKILL++ Library\n")
  ))

  list(nil
    'VrtImport VrtImport
    'Initialize Initialize
    'GetCurrentFilePath GetCurrentFilePath
    'GetCurrentFileDirectory GetCurrentFileDirectory
    'OpenDocumentation OpenDocumentation
    'OpenDocumentationLmgrCallback OpenDocumentationLmgrCallback
))

VrtImport['Virtue] = Virtue
Virtue->Initialize()
)

; Global functions required for library manager
VrtOpenDocumentationLmgrCallback =
	VrtImport['Virtue]->OpenDocumentationLmgrCallback
