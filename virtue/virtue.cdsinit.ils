; Define the iport table as a global in both SKILL and SKILL++
inSkill(Import = makeTable("Virtue Module Import Table"))
importSkillVar(Import)

let((Virtue)

Virtue = let(((module_description "SKILL++ Library and package manager")
             )

  procedure(GetCurrentFilePath()
    simplifyFilename(get_filename(piport))
  )

  procedure(GetCurrentFileDirectory()
    let((file_path)
    file_path = GetCurrentFilePath()
    strcat("/" buildString(reverse(cdr(reverse(parseString(file_path "/")))) "/"))
  ))

  procedure(OpenDocumentation()
    system("firefox http://www.cascode-labs.org/virtue/ &")
  )

  procedure(OpenDocumentationLmgrCallback(_menuItem _lib _cell _view _file _cat)
    "Callback to open the Virtue help from the library manager window"
    OpenDocumentation()
  )

  procedure(Initialize()
    let((dir_path preinit_packages Module Project virtue_packages)
    printf("\nInitializing Virtue SKILL++ Library\n")

    dir_path = GetCurrentFileDirectory()

    loadi(strcat(dir_path "/skill_package/Module.ils"))
    Module = Import['Module]
    Virtue = Module->New('Virtue Import['Virtue]
      ?project Import['Virtue]
      ?description module_description)

    preinit_packages = list(
      "data_types/Str.ils"
      "skill_package/Path.ils"
      "Toml.ils"
      "skill_package/Package.ils"
    )
    Module->LoadList(preinit_packages
      ?root_path dir_path
      ?continue_on_error 't)

    Package = Import['Package]
    Package->New(Virtue dir_path)

    virtue_packages = list(
      "data_types/List.ils"
    	"test/Test.ils"
    	"Geo.ils"
      "data_types/Dpl.ils"
      "data_types/Lcv.ils"
    	; "Sch.ils"
    	"MaeMaestro.ils"
      "MaeExport.ils"
    	; "skillBridgeMenuItems.il"
    	; "filePathFromLCV.il"
      ; "SchNets.il"
      "HdbConfig.ils"
      "Skillbridge.ils"
    )
    Module->LoadList(virtue_packages
      ?root_path dir_path
      ?continue_on_error 't)
    printf("  Initialized Virtue SKILL++ Library\n")
  ))

  list(nil
    'Import Import
    'Initialize Initialize
    'GetCurrentFilePath GetCurrentFilePath
    'GetCurrentFileDirectory GetCurrentFileDirectory
    'OpenDocumentation OpenDocumentation
    'OpenDocumentationLmgrCallback OpenDocumentationLmgrCallback
))

Import['Virtue] = Virtue
Virtue->Initialize()
)

; Global functions required for library manager
VrtOpenDocumentationLmgrCallback =
	Import['Virtue]->OpenDocumentationLmgrCallback
