; Point Geometry Module
; -------------------------
; Built-in Point Functions:
;  * isLocation
;  * xCoord
;  * yCoord
;  * dbTransformPoint
;  * dbTransformPointList
;  * dbConcatTransform

let(((Geo VrtImport('Geo))
     (Dpl VrtImport('Dpl))
    )

  procedure(ptOffset(P offset "ll")
    "Offset a point or sum 2 points"
    list(xCoord(P)+xCoord(offset)
      yCoord(P)+yCoord(offset))
  )

  procedure(ptNeg(P "l")
    "Negates both the x and Y of the given point"
    list(-xCoord(P) -yCoord(P))
  )

  procedure(ptProduct(P Multiplier "lg")
    "Multiplies the point, P, by the given Multiplier

    @param P The point as a (X,Y) list
    @param Multiplier Either a scalar to multiply with both the X and Y or
    an (X,Y) list containing seperate multipliers for each coordinate"
    cond(
      (floatp(Multiplier) || integerp(Multiplier)
        ptProductScalar(P Multiplier))
      (isLocation(Multiplier)
        ptProductVector(P Multiplier))
      ('t
        error("Multiplier type is not supported")))
  )

  procedure(ptProductScalar(P Multiplier "ln")
  	"Multiplys the point, P, by the given scalar Multiplier

    @param P The point as a (X,Y) list
    @param Multiplier A scalar to multiply with both the X and Y"
  	list(xCoord(P)*Multiplier yCoord(P)*Multiplier)
  )

  procedure(ptProductVector(P Multiplier "ll")
    "Multiplys the point, P, by the given scalar Multiplier

    @param P The point as a (X,Y) list
    @param Multiplier An (X,Y) list containing seperate multipliers for each
  	coordinate"
  	list(xCoord(P)*xCoord(Multiplier) yCoord(P)*yCoord(Multiplier))
  )

  procedure(ptDistance(P1 P2 "ll")
    "Calculates the distance between 2 points."
    sqrt(expt(xCoord(P2) - xCoord(P1) 2) + expt(yCoord(P2) - yCoord(P1) 2)))

  procedure( ptInBoxp( point box "ll")
    "Checks if the point is inside the bounding box or on the box edge.

  	@return inside_box a boolean"
  	xCoord(point) >= leftEdge(box)&&
  	xCoord(point) <= rightEdge(box) &&
  	yCoord(point) >= bottomEdge(box) &&
  	yCoord(point) <= topEdge(box)
  )

  procedure( ptNearestBoxSide(point box "ll")
    "Finds the nearest side of the box to the reference point
  	@return side A string, 'left', 'right', 'top', or 'bottom'"
  	let((x1 y1 x2 y2 x y d1 d2 d3 d4 minDist side)

  	x1 = caar( box )
  	y1 = cadar( box )
  	x2 = caadr( box )
  	y2 = cadadr( box )

  	x = xCoord( point )
  	y = yCoord( point )

  	if( Geo->ptInBoxp(point box) then
  		d1 = x - x1 ; left distance
  		d2 = y - y1 ; bottom distance
  		d3 = x2 - x ; right distance
  		d4 = y2 - y ; top distance

  		minDist = min( d1 d2 d3 d4 )
  		cond(
  			( minDist == d1 side = "left")
  			( minDist == d2 side = "bottom")
  			( minDist == d3 side = "right")
  			( minDist == d4 side = "top")
  		)
  	else
  		; point is outside the box.
  		;  A diagnol line between each corner and the center splits the sides
  		cond(
  			( x > max(x1 x2) ; To the right of the box
  				side = "right"
  				cond(
  					( y > max(y1 y2) &&
  					 (y - max(y1 y2)) > (x - max(x1 x2))
  						side = "top"
  					)
  					( y < min(y1 y2) &&
  					 (min(y1 y2) - y) > (x - max(x1 x2))
  						side = "bottom"
  					)
  				)
              )
  			( x < min(x1 x2) ; To the left of the box
  				side = "left"
  				cond(
  					( y > max(y1 y2) &&
  					 (y - max(y1 y2)) > (min(x1 x2) - x)
  						side = "top"
              			)
  					( y < min(y1 y2) &&
  					 (min(y1 y2) - y) > (min(x1 x2) - x)
                  			side = "bottom"
  					)
  				)
  			)
  			( t ; straight above or below the box
  				cond(
  					( y > max(y1 y2) side = "top" )
  					( y < min(y1 y2) side = "bottom" )
  				)
  			)
  		)
      )
      side
  ))

  procedure(ptSnapToGrid( pt grid @optional noLarger)
  	"Snap the point to the grid"
  	numSnapToGrid(xCoord(pt) grid noLarger):
  	numSnapToGrid(yCoord(pt) grid noLarger)
  )

  procedure(numSnapToGrid( number grid @optional noLarger)
    "Snap a number to the grid"
    let((out)
      if( noLarger then
        out = fix(abs(number)/grid) * grid
      else
        out = round(abs(number)/grid) * grid
      )
  	when(negativep(number)  ; negative number
        out = -out
      )
  ))

  Geo = Dpl->Cat(Geo list(nil
  	'ptOffset ptOffset
  	'ptNeg ptNeg
  	'ptProduct ptProduct
  	'ptDistance ptDistance
  	'ptInBoxp ptInBoxp
  	'ptNearestBoxSide ptNearestBoxSide
  	'ptSnapToGrid ptSnapToGrid
  ))
)
